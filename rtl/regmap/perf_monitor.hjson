{
	name: "perf_monitor",
    clock_primary: "clk_i",
	reset_primary: "rst_ni",
	bus_interfaces: [{
	    protocol: "reg_iface",
	    direction: "device"
    }],
    regwidth: "32",
	registers: [
        # Info Registers
        {
            name: "perf_data",
            desc: "Indicates the performance in the read channel",
            swaccess: "ro",
            hwaccess: "hrw",
            fields: [
                {
                    bits: "30:0",
                    name: "data",
                    desc: "Indicates the performance in the read channel",
                    resval: "0"
                },
                {
                    bits: "31:31",
                    name: "v",
                    desc: "Indicates valid",
                    resval: "0"
                },
            ]
        },
    ]
}